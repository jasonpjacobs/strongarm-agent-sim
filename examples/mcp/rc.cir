Clock-free RC transient with controllable voltage and load current
VIN in 0 dc 0 external
R1 in out 1k
C1 out 0 1n
ILOAD out 0 dc 0 external
.save v(in) v(out) i(VIN)
.options reltol=1e-6 abstol=1e-12 vntol=1e-8
.end
